`include "discipline.h"
`include "constants.h"

//
// 3-input AND gate
//
// vin1, vin2, vin3: [V, A]
// vout:             [V, A]
//
// Parameters:
//    vlogic_high = output voltage for high [V]
//    vlogic_low  = output voltage for low [V]
//    vtrans      = threshold voltage to determine logic HIGH [V]
//    tdel, trise, tfall = timing parameters [s]
//

module and3_gate(vin1, vin2, vin3, vout);
  input vin1, vin2, vin3;
  output vout;
  electrical vin1, vin2, vin3, vout;

  parameter real vlogic_high = 5;
  parameter real vlogic_low = 0;
  parameter real vtrans = 1.4;
  parameter real tdel = 2u from [0:inf);
  parameter real trise = 1u from (0:inf);
  parameter real tfall = 1u from (0:inf);

  real vout_val;
  integer logic1, logic2, logic3;

  analog begin
    @ (initial_step) begin
      if (vlogic_high < vlogic_low) begin
        $display("Range specification error.  vlogic_high = (%E) less than vlogic_low = (%E).\n",
                 vlogic_high, vlogic_low );
        $finish;
      end
      if (vtrans > vlogic_high || vtrans < vlogic_low) begin
        $display("Inconsistent vtrans specification w/logic family.\n");
      end
    end

    // Initial logic level
    logic1 = V(vin1) > vtrans;
    logic2 = V(vin2) > vtrans;
    logic3 = V(vin3) > vtrans;

    // Edge-triggered logic updates
    @ (cross(V(vin1) - vtrans,  1)) logic1 = 1;
    @ (cross(V(vin1) - vtrans, -1)) logic1 = 0;
    @ (cross(V(vin2) - vtrans,  1)) logic2 = 1;
    @ (cross(V(vin2) - vtrans, -1)) logic2 = 0;
    @ (cross(V(vin3) - vtrans,  1)) logic3 = 1;
    @ (cross(V(vin3) - vtrans, -1)) logic3 = 0;

    // 3-input AND logic
    vout_val = (logic1 && logic2 && logic3) ? vlogic_high : vlogic_low;

    V(vout) <+ transition(vout_val, tdel, trise, tfall);
  end
endmodule
